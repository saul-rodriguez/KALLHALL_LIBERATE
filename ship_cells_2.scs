// Design: KALLHALL_STD_LIB3/timing
simulator lang=spectre
global 0 vss vdd

// KALLHALL_STD_LIB3/INVX1/schematic
subckt INVX1 Y A vdd vss
    M1 (Y A vss vss) nch w=2u l=1u
    M0 (Y A vdd vdd) pch w=4u l=1u
ends INVX1

// KALLHALL_STD_LIB3/NOR2X1/schematic
subckt NOR2X1 Y A B vdd vss
    M2 (Y B vss vss) nch w=2u l=1u
    M1 (Y A vss vss) nch w=2u l=1u
    M3 (Y B net018 vdd) pch w=4u l=1u
    M0 (net018 A vdd vdd) pch w=4u l=1u
ends NOR2X1

// KALLHALL_STD_LIB3/BUFX2/schematic
subckt BUFX2 Y A vdd vss
    M2 (Y net022 vss vss) nch w=2u l=1u
    M1 (net022 A vss vss) nch w=2u l=1u
    M3 (Y net022 vdd vdd) pch w=4u l=1u
    M0 (net022 A vdd vdd) pch w=4u l=1u
ends BUFX2

// KALLHALL_STD_LIB3/NAND2X1/schematic
subckt NAND2X1 Y A B vdd vss
    M2 (net17 A vss vss) nch w=2u l=1u
    M1 (Y B net17 vss) nch w=2u l=1u
    M3 (Y A vdd vdd) pch w=4u l=1u
    M0 (Y B vdd vdd) pch w=4u l=1u
ends NAND2X1

// KALLHALL_STD_LIB3/DFFX1/schematic
subckt DFFX1 Q QN CK D vdd vss
    M26 (QN net058 vss vss) nch w=2u l=1u
    M24 (net058 qbint vss vss) nch w=2u l=1u
    M22 (Q qbint vss vss) nch w=2u l=1u
    M21 (n30 CKb net053 vss) nch w=2u l=1u
    M20 (net053 qbint vss vss) nch w=2u l=1u
    M16 (qbint n30 vss vss) nch w=2u l=1u
    M14 (n30 CKbb mout vss) nch w=2u l=1u
    M13 (n20 CKbb net038 vss) nch w=2u l=1u
    M12 (net038 mout vss vss) nch w=2u l=1u
    M8 (mout n20 vss vss) nch w=2u l=1u
    M7 (n20 CKb net25 vss) nch w=2u l=1u
    M6 (net25 D vss vss) nch w=2u l=1u
    M2 (CKbb CKb vss vss) nch w=2u l=1u
    M1 (CKb CK vss vss) nch w=2u l=1u
    M27 (QN net058 vdd vdd) pch w=4u l=1u
    M25 (net058 qbint vdd vdd) pch w=4u l=1u
    M23 (Q qbint vdd vdd) pch w=4u l=1u
    M19 (n30 CKbb net054 vdd) pch w=4u l=1u
    M18 (net054 qbint vdd vdd) pch w=4u l=1u
    M17 (qbint n30 vdd vdd) pch w=4u l=1u
    M15 (n30 CKb mout vdd) pch w=4u l=1u
    M11 (n20 CKb net039 vdd) pch w=4u l=1u
    M10 (net039 mout vdd vdd) pch w=4u l=1u
    M9 (mout n20 vdd vdd) pch w=4u l=1u
    M5 (n20 CKbb net26 vdd) pch w=4u l=1u
    M4 (net26 D vdd vdd) pch w=4u l=1u
    M3 (CKbb CKb vdd vdd) pch w=4u l=1u
    M0 (CKb CK vdd vdd) pch w=4u l=1u
ends DFFX1

// KALLHALL_STD_LIB3/timing/schematic
I0 (net1 net2 VDD! VSS!) INVX1
I1 (net3 net4 net5 VDD! VSS!) NOR2X1
I2 (net6 net7 VDD! VSS!) BUFX2
I3 (net8 net9 net10 VDD! VSS!) NAND2X1
I4 (net011 net012 net013 net014 VDD! VSS!) DFFX1
simulatorOptions options temp=27
